* Extracted by KLayout with GF180MCU LVS runset on : 23/11/2025 21:13

.SUBCKT FF_v1 VDD Q GND RST CLK D
M$1 \$3 \$7 VDD VDD pfet_03v3 L=0.28U W=0.84U AS=0.546P AD=0.2184P PS=2.98U
+ PD=1.36U
M$2 VDD \$6 \$3 VDD pfet_03v3 L=0.28U W=0.84U AS=0.2184P AD=0.546P PS=1.36U
+ PD=2.98U
M$3 Q RST VDD VDD pfet_03v3 L=0.28U W=0.84U AS=0.546P AD=0.2184P PS=2.98U
+ PD=1.36U
M$4 VDD \$3 Q VDD pfet_03v3 L=0.28U W=0.84U AS=0.2184P AD=0.546P PS=1.36U
+ PD=2.98U
M$5 \$6 \$5 VDD VDD pfet_03v3 L=0.28U W=0.84U AS=0.546P AD=0.546P PS=2.98U
+ PD=2.98U
M$6 \$18 \$5 VDD VDD pfet_03v3 L=0.28U W=0.84U AS=0.546P AD=0.2184P PS=2.98U
+ PD=1.36U
M$7 VDD \$7 \$18 VDD pfet_03v3 L=0.28U W=0.84U AS=0.2184P AD=0.546P PS=1.36U
+ PD=2.98U
M$8 RST \$18 VDD VDD pfet_03v3 L=0.28U W=0.84U AS=0.546P AD=0.2184P PS=2.98U
+ PD=1.36U
M$9 VDD Q RST VDD pfet_03v3 L=0.28U W=0.84U AS=0.2184P AD=0.546P PS=1.36U
+ PD=2.98U
M$10 \$7 CLK VDD VDD pfet_03v3 L=0.28U W=0.84U AS=0.546P AD=0.546P PS=2.98U
+ PD=2.98U
M$11 \$28 D VDD VDD pfet_03v3 L=0.28U W=0.84U AS=0.546P AD=0.2184P PS=2.98U
+ PD=1.36U
M$12 VDD CLK \$28 VDD pfet_03v3 L=0.28U W=0.84U AS=0.2184P AD=0.546P PS=1.36U
+ PD=2.98U
M$13 \$5 \$28 VDD VDD pfet_03v3 L=0.28U W=0.84U AS=0.546P AD=0.2184P PS=2.98U
+ PD=1.36U
M$14 VDD \$31 \$5 VDD pfet_03v3 L=0.28U W=0.84U AS=0.2184P AD=0.546P PS=1.36U
+ PD=2.98U
M$15 \$38 D VDD VDD pfet_03v3 L=0.28U W=0.84U AS=0.546P AD=0.546P PS=2.98U
+ PD=2.98U
M$16 \$40 CLK VDD VDD pfet_03v3 L=0.28U W=0.84U AS=0.546P AD=0.2184P PS=2.98U
+ PD=1.36U
M$17 VDD \$38 \$40 VDD pfet_03v3 L=0.28U W=0.84U AS=0.2184P AD=0.546P PS=1.36U
+ PD=2.98U
M$18 \$31 \$5 VDD VDD pfet_03v3 L=0.28U W=0.84U AS=0.546P AD=0.2184P PS=2.98U
+ PD=1.36U
M$19 VDD \$40 \$31 VDD pfet_03v3 L=0.28U W=0.84U AS=0.2184P AD=0.546P PS=1.36U
+ PD=2.98U
M$20 \$11 \$7 GND GND nfet_03v3 L=0.28U W=0.42U AS=0.2646P AD=0.1092P PS=2.1U
+ PD=0.94U
M$21 \$11 \$6 \$3 GND nfet_03v3 L=0.28U W=0.42U AS=0.2646P AD=0.1092P PS=2.1U
+ PD=0.94U
M$22 \$12 RST GND GND nfet_03v3 L=0.28U W=0.42U AS=0.2646P AD=0.1092P PS=2.1U
+ PD=0.94U
M$23 \$12 \$3 Q GND nfet_03v3 L=0.28U W=0.42U AS=0.2646P AD=0.1092P PS=2.1U
+ PD=0.94U
M$24 \$6 \$5 GND GND nfet_03v3 L=0.28U W=0.42U AS=0.2646P AD=0.2646P PS=2.1U
+ PD=2.1U
M$25 \$17 \$5 GND GND nfet_03v3 L=0.28U W=0.42U AS=0.2646P AD=0.1092P PS=2.1U
+ PD=0.94U
M$26 \$17 \$7 \$18 GND nfet_03v3 L=0.28U W=0.42U AS=0.2646P AD=0.1092P PS=2.1U
+ PD=0.94U
M$27 \$19 \$18 GND GND nfet_03v3 L=0.28U W=0.42U AS=0.2646P AD=0.1092P PS=2.1U
+ PD=0.94U
M$28 \$19 Q RST GND nfet_03v3 L=0.28U W=0.42U AS=0.2646P AD=0.1092P PS=2.1U
+ PD=0.94U
M$29 GND CLK \$7 GND nfet_03v3 L=0.28U W=0.42U AS=0.2646P AD=0.2562P PS=2.1U
+ PD=2.06U
M$30 \$34 D GND GND nfet_03v3 L=0.28U W=0.42U AS=0.2646P AD=0.1092P PS=2.1U
+ PD=0.94U
M$31 \$34 CLK \$28 GND nfet_03v3 L=0.28U W=0.42U AS=0.2646P AD=0.1092P PS=2.1U
+ PD=0.94U
M$32 \$35 \$28 GND GND nfet_03v3 L=0.28U W=0.42U AS=0.2646P AD=0.1092P PS=2.1U
+ PD=0.94U
M$33 \$35 \$31 \$5 GND nfet_03v3 L=0.28U W=0.42U AS=0.2646P AD=0.1092P PS=2.1U
+ PD=0.94U
M$34 \$38 D GND GND nfet_03v3 L=0.28U W=0.42U AS=0.2646P AD=0.2646P PS=2.1U
+ PD=2.1U
M$35 \$39 CLK GND GND nfet_03v3 L=0.28U W=0.42U AS=0.2646P AD=0.1092P PS=2.1U
+ PD=0.94U
M$36 \$39 \$38 \$40 GND nfet_03v3 L=0.28U W=0.42U AS=0.2646P AD=0.1092P PS=2.1U
+ PD=0.94U
M$37 \$41 \$5 GND GND nfet_03v3 L=0.28U W=0.42U AS=0.2646P AD=0.1092P PS=2.1U
+ PD=0.94U
M$38 \$41 \$40 \$31 GND nfet_03v3 L=0.28U W=0.42U AS=0.2646P AD=0.1092P PS=2.1U
+ PD=0.94U
.ENDS FF_v1
