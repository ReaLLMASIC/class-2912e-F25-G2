* Extracted by KLayout with GF180MCU LVS runset on : 25/11/2025 19:16

.SUBCKT XOR Y A GND B VDD
M$1 Y B A VDD pfet_03v3 L=1U W=2U AS=1.3P AD=1.3P PS=5.3U PD=5.3U
M$2 \$6 B VDD VDD pfet_03v3 L=0.28U W=0.84U AS=0.546P AD=0.546P PS=2.98U
+ PD=2.98U
M$3 \$11 A VDD VDD pfet_03v3 L=0.28U W=0.84U AS=0.546P AD=0.546P PS=2.98U
+ PD=2.98U
M$4 Y \$6 \$11 VDD pfet_03v3 L=1U W=2U AS=1.3P AD=1.3P PS=5.3U PD=5.3U
M$5 \$6 B GND GND nfet_03v3 L=0.28U W=0.42U AS=0.2646P AD=0.2646P PS=2.1U
+ PD=2.1U
M$6 Y \$6 A GND nfet_03v3 L=1U W=1U AS=0.61P AD=0.61P PS=3.22U PD=3.22U
M$7 \$11 A GND GND nfet_03v3 L=0.28U W=0.42U AS=0.2646P AD=0.2646P PS=2.1U
+ PD=2.1U
M$8 Y B \$11 GND nfet_03v3 L=1U W=1U AS=0.61P AD=0.61P PS=3.22U PD=3.22U
.ENDS XOR
