* Extracted by KLayout with GF180MCU LVS runset on : 23/11/2025 19:49

.SUBCKT SRlatch VDD QB D CLK Q GND
M$1 \$3 CLK VDD VDD pfet_03v3 L=0.28U W=0.84U AS=0.546P AD=0.2184P PS=2.98U
+ PD=1.36U
M$2 VDD \$6 \$3 VDD pfet_03v3 L=0.28U W=0.84U AS=0.2184P AD=0.546P PS=1.36U
+ PD=2.98U
M$3 QB Q VDD VDD pfet_03v3 L=0.28U W=0.84U AS=0.546P AD=0.2184P PS=2.98U
+ PD=1.36U
M$4 VDD \$3 QB VDD pfet_03v3 L=0.28U W=0.84U AS=0.2184P AD=0.546P PS=1.36U
+ PD=2.98U
M$5 \$6 D VDD VDD pfet_03v3 L=0.28U W=0.84U AS=0.546P AD=0.546P PS=2.98U
+ PD=2.98U
M$6 \$19 D VDD VDD pfet_03v3 L=0.28U W=0.84U AS=0.546P AD=0.2184P PS=2.98U
+ PD=1.36U
M$7 VDD CLK \$19 VDD pfet_03v3 L=0.28U W=0.84U AS=0.2184P AD=0.546P PS=1.36U
+ PD=2.98U
M$8 Q \$19 VDD VDD pfet_03v3 L=0.28U W=0.84U AS=0.546P AD=0.2184P PS=2.98U
+ PD=1.36U
M$9 VDD QB Q VDD pfet_03v3 L=0.28U W=0.84U AS=0.2184P AD=0.546P PS=1.36U
+ PD=2.98U
M$10 \$12 CLK GND GND nfet_03v3 L=0.28U W=0.42U AS=0.2646P AD=0.1092P PS=2.1U
+ PD=0.94U
M$11 \$12 \$6 \$3 GND nfet_03v3 L=0.28U W=0.42U AS=0.2646P AD=0.1092P PS=2.1U
+ PD=0.94U
M$12 \$13 Q GND GND nfet_03v3 L=0.28U W=0.42U AS=0.2646P AD=0.1092P PS=2.1U
+ PD=0.94U
M$13 \$13 \$3 QB GND nfet_03v3 L=0.28U W=0.42U AS=0.2646P AD=0.1092P PS=2.1U
+ PD=0.94U
M$14 \$6 D GND GND nfet_03v3 L=0.28U W=0.42U AS=0.2646P AD=0.2646P PS=2.1U
+ PD=2.1U
M$15 \$18 D GND GND nfet_03v3 L=0.28U W=0.42U AS=0.2646P AD=0.1092P PS=2.1U
+ PD=0.94U
M$16 \$18 CLK \$19 GND nfet_03v3 L=0.28U W=0.42U AS=0.2646P AD=0.1092P PS=2.1U
+ PD=0.94U
M$17 \$20 \$19 GND GND nfet_03v3 L=0.28U W=0.42U AS=0.2646P AD=0.1092P PS=2.1U
+ PD=0.94U
M$18 \$20 QB Q GND nfet_03v3 L=0.28U W=0.42U AS=0.2646P AD=0.1092P PS=2.1U
+ PD=0.94U
.ENDS SRlatch
