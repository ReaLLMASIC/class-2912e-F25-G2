* Extracted by KLayout with GF180MCU LVS runset on : 19/11/2025 00:16

.SUBCKT NAND GND VOUT A B VDD
M$1 VOUT A VDD VDD pfet_03v3 L=0.28U W=0.84U AS=0.546P AD=0.2184P PS=2.98U
+ PD=1.36U
M$2 VDD B VOUT VDD pfet_03v3 L=0.28U W=0.84U AS=0.2184P AD=0.546P PS=1.36U
+ PD=2.98U
M$3 \$2 A GND GND nfet_03v3 L=0.28U W=0.42U AS=0.2646P AD=0.1092P PS=2.1U
+ PD=0.94U
M$4 \$2 B VOUT GND nfet_03v3 L=0.28U W=0.42U AS=0.2646P AD=0.1092P PS=2.1U
+ PD=0.94U
.ENDS NAND
