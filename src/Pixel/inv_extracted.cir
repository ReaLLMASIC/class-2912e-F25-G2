* Extracted by KLayout with GF180MCU LVS runset on : 19/11/2025 19:00

.SUBCKT inv VSS VDD VOUT VIN
M$1 VOUT VIN VDD VDD pfet_03v3 L=0.28U W=0.84U AS=0.546P AD=0.546P PS=2.98U
+ PD=2.98U
M$2 VOUT VIN VSS VSS nfet_03v3 L=0.28U W=0.42U AS=0.2646P AD=0.2646P PS=2.1U
+ PD=2.1U
.ENDS inv
