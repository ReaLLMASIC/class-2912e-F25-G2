* Extracted by KLayout with GF180MCU LVS runset on : 19/11/2025 18:50

.SUBCKT TOP
M$1 VOUT VIN VDD VDD pfet_03v3 L=0.28U W=0.42U AS=0.2822P AD=0.2822P PS=2.18U
+ PD=2.18U
M$2 VOUT VIN VSS VSS nfet_03v3 L=0.28U W=0.84U AS=0.5124P AD=0.5124P PS=2.9U
+ PD=2.9U
.ENDS TOP
