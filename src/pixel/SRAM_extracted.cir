* Extracted by KLayout with GF180MCU LVS runset on : 18/11/2025 00:45

.SUBCKT SRAM GND VDD WL BLB BL
M$1 VDD \$4 \$3 VDD pfet_03v3 L=0.28U W=0.42U AS=0.2822P AD=0.1092P PS=2.18U
+ PD=0.94U
M$2 VDD \$3 \$4 VDD pfet_03v3 L=0.28U W=0.42U AS=0.2822P AD=0.1092P PS=2.18U
+ PD=0.94U
M$3 GND \$4 \$3 GND nfet_03v3 L=0.28U W=0.84U AS=0.5124P AD=0.2184P PS=2.9U
+ PD=1.36U
M$4 \$4 \$3 GND GND nfet_03v3 L=0.28U W=0.84U AS=0.2184P AD=0.5124P PS=1.36U
+ PD=2.9U
M$5 BLB WL \$4 GND nfet_03v3 L=0.28U W=0.42U AS=0.2646P AD=0.2646P PS=2.1U
+ PD=2.1U
M$6 BL WL \$3 GND nfet_03v3 L=0.28U W=0.42U AS=0.2646P AD=0.2646P PS=2.1U
+ PD=2.1U
.ENDS SRAM
