* Extracted by KLayout with GF180MCU LVS runset on : 27/11/2025 00:44

.SUBCKT TG GND VDD SW IN OUT SWB
M$1 OUT SWB IN VDD pfet_03v3 L=0.28U W=0.42U AS=0.2822P AD=0.2822P PS=2.18U
+ PD=2.18U
M$2 OUT SW IN GND nfet_03v3 L=0.28U W=0.42U AS=0.2646P AD=0.2646P PS=2.1U
+ PD=2.1U
.ENDS TG
