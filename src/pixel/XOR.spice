** sch_path: /foss/designs/pixel/XOR.sch
.subckt XOR VDD A B GND Y
*.PININFO A:B B:B GND:B VDD:B Y:B
x1 A_b B B_b VDD GND Y TG
x2 A B_b B VDD GND Y TG
x3 VDD A A_b GND inv
x4 VDD B B_b GND inv
.ends

* expanding   symbol:  pixel/TG.sym # of pins=6
** sym_path: /foss/designs/pixel/TG.sym
** sch_path: /foss/designs/pixel/TG.sch
.subckt TG In SW SWB VDD GND Out
*.PININFO In:B Out:B SW:B GND:B VDD:B SWB:B
M1 In SW Out GND nfet_03v3 L=1u W=1u nf=1 m=1
M2 Out SWB In VDD pfet_03v3 L=1u W=2u nf=1 m=1
.ends

* expanding   symbol:  pixel/inv.sym # of pins=4
** sym_path: /foss/designs/pixel/inv.sym
** sch_path: /foss/designs/pixel/inv.sch
.subckt inv vdd vin vout vss
*.PININFO vin:B vout:B vdd:B vss:B
M1 vout vin vss vss nfet_03v3 L=0.28u W=0.42u nf=1 m=1
M2 vout vin vdd vdd pfet_03v3 L=0.28u W=0.84u nf=1 m=1
.ends
