* Extracted by KLayout with GF180MCU LVS runset on : 26/11/2025 18:26

.SUBCKT SRAM8bit GND WL BL[1] VDD BLB[1] BLB[3] BL[3] BL[5] BLB[5] BLB[7] BL[7]
+ BL[0] BLB[0] BLB[2] BL[2] BL[4] BLB[4] BLB[6] BL[6]
M$1 VDD \$7 \$2 VDD pfet_03v3 L=0.28U W=0.42U AS=0.2822P AD=0.1092P PS=2.18U
+ PD=0.94U
M$2 VDD \$2 \$7 VDD pfet_03v3 L=0.28U W=0.42U AS=0.2822P AD=0.1092P PS=2.18U
+ PD=0.94U
M$3 VDD \$8 \$3 VDD pfet_03v3 L=0.28U W=0.42U AS=0.2822P AD=0.1092P PS=2.18U
+ PD=0.94U
M$4 VDD \$3 \$8 VDD pfet_03v3 L=0.28U W=0.42U AS=0.2822P AD=0.1092P PS=2.18U
+ PD=0.94U
M$5 VDD \$9 \$4 VDD pfet_03v3 L=0.28U W=0.42U AS=0.2822P AD=0.1092P PS=2.18U
+ PD=0.94U
M$6 VDD \$4 \$9 VDD pfet_03v3 L=0.28U W=0.42U AS=0.2822P AD=0.1092P PS=2.18U
+ PD=0.94U
M$7 VDD \$10 \$5 VDD pfet_03v3 L=0.28U W=0.42U AS=0.2822P AD=0.1092P PS=2.18U
+ PD=0.94U
M$8 VDD \$5 \$10 VDD pfet_03v3 L=0.28U W=0.42U AS=0.2822P AD=0.1092P PS=2.18U
+ PD=0.94U
M$9 VDD \$54 \$37 VDD pfet_03v3 L=0.28U W=0.42U AS=0.2822P AD=0.1092P PS=2.18U
+ PD=0.94U
M$10 VDD \$37 \$54 VDD pfet_03v3 L=0.28U W=0.42U AS=0.2822P AD=0.1092P PS=2.18U
+ PD=0.94U
M$11 VDD \$41 \$40 VDD pfet_03v3 L=0.28U W=0.42U AS=0.2822P AD=0.1092P PS=2.18U
+ PD=0.94U
M$12 VDD \$40 \$41 VDD pfet_03v3 L=0.28U W=0.42U AS=0.2822P AD=0.1092P PS=2.18U
+ PD=0.94U
M$13 VDD \$55 \$44 VDD pfet_03v3 L=0.28U W=0.42U AS=0.2822P AD=0.1092P PS=2.18U
+ PD=0.94U
M$14 VDD \$44 \$55 VDD pfet_03v3 L=0.28U W=0.42U AS=0.2822P AD=0.1092P PS=2.18U
+ PD=0.94U
M$15 VDD \$48 \$47 VDD pfet_03v3 L=0.28U W=0.42U AS=0.2822P AD=0.1092P PS=2.18U
+ PD=0.94U
M$16 VDD \$47 \$48 VDD pfet_03v3 L=0.28U W=0.42U AS=0.2822P AD=0.1092P PS=2.18U
+ PD=0.94U
M$17 GND \$7 \$2 GND nfet_03v3 L=0.28U W=0.84U AS=0.5124P AD=0.2184P PS=2.9U
+ PD=1.36U
M$18 \$7 \$2 GND GND nfet_03v3 L=0.28U W=0.84U AS=0.2184P AD=0.5124P PS=1.36U
+ PD=2.9U
M$19 GND \$8 \$3 GND nfet_03v3 L=0.28U W=0.84U AS=0.5124P AD=0.2184P PS=2.9U
+ PD=1.36U
M$20 \$8 \$3 GND GND nfet_03v3 L=0.28U W=0.84U AS=0.2184P AD=0.5124P PS=1.36U
+ PD=2.9U
M$21 GND \$9 \$4 GND nfet_03v3 L=0.28U W=0.84U AS=0.5124P AD=0.2184P PS=2.9U
+ PD=1.36U
M$22 \$9 \$4 GND GND nfet_03v3 L=0.28U W=0.84U AS=0.2184P AD=0.5124P PS=1.36U
+ PD=2.9U
M$23 GND \$10 \$5 GND nfet_03v3 L=0.28U W=0.84U AS=0.5124P AD=0.2184P PS=2.9U
+ PD=1.36U
M$24 \$10 \$5 GND GND nfet_03v3 L=0.28U W=0.84U AS=0.2184P AD=0.5124P PS=1.36U
+ PD=2.9U
M$25 BLB[1] WL \$7 GND nfet_03v3 L=0.28U W=0.42U AS=0.2646P AD=0.2646P PS=2.1U
+ PD=2.1U
M$26 BLB[3] WL \$3 GND nfet_03v3 L=0.28U W=0.42U AS=0.2646P AD=0.2646P PS=2.1U
+ PD=2.1U
M$27 BLB[5] WL \$9 GND nfet_03v3 L=0.28U W=0.42U AS=0.2646P AD=0.2646P PS=2.1U
+ PD=2.1U
M$28 BLB[7] WL \$5 GND nfet_03v3 L=0.28U W=0.42U AS=0.2646P AD=0.2646P PS=2.1U
+ PD=2.1U
M$29 BL[1] WL \$2 GND nfet_03v3 L=0.28U W=0.42U AS=0.2646P AD=0.2646P PS=2.1U
+ PD=2.1U
M$30 BL[3] WL \$8 GND nfet_03v3 L=0.28U W=0.42U AS=0.2646P AD=0.2646P PS=2.1U
+ PD=2.1U
M$31 BL[5] WL \$4 GND nfet_03v3 L=0.28U W=0.42U AS=0.2646P AD=0.2646P PS=2.1U
+ PD=2.1U
M$32 BL[7] WL \$10 GND nfet_03v3 L=0.28U W=0.42U AS=0.2646P AD=0.2646P PS=2.1U
+ PD=2.1U
M$33 \$37 WL BL[0] GND nfet_03v3 L=0.28U W=0.42U AS=0.2646P AD=0.2646P PS=2.1U
+ PD=2.1U
M$34 \$41 WL BL[2] GND nfet_03v3 L=0.28U W=0.42U AS=0.2646P AD=0.2646P PS=2.1U
+ PD=2.1U
M$35 \$44 WL BL[4] GND nfet_03v3 L=0.28U W=0.42U AS=0.2646P AD=0.2646P PS=2.1U
+ PD=2.1U
M$36 \$48 WL BL[6] GND nfet_03v3 L=0.28U W=0.42U AS=0.2646P AD=0.2646P PS=2.1U
+ PD=2.1U
M$37 \$54 WL BLB[0] GND nfet_03v3 L=0.28U W=0.42U AS=0.2646P AD=0.2646P PS=2.1U
+ PD=2.1U
M$38 \$40 WL BLB[2] GND nfet_03v3 L=0.28U W=0.42U AS=0.2646P AD=0.2646P PS=2.1U
+ PD=2.1U
M$39 \$55 WL BLB[4] GND nfet_03v3 L=0.28U W=0.42U AS=0.2646P AD=0.2646P PS=2.1U
+ PD=2.1U
M$40 \$47 WL BLB[6] GND nfet_03v3 L=0.28U W=0.42U AS=0.2646P AD=0.2646P PS=2.1U
+ PD=2.1U
M$41 GND \$54 \$37 GND nfet_03v3 L=0.28U W=0.84U AS=0.5124P AD=0.2184P PS=2.9U
+ PD=1.36U
M$42 \$54 \$37 GND GND nfet_03v3 L=0.28U W=0.84U AS=0.2184P AD=0.5124P PS=1.36U
+ PD=2.9U
M$43 GND \$41 \$40 GND nfet_03v3 L=0.28U W=0.84U AS=0.5124P AD=0.2184P PS=2.9U
+ PD=1.36U
M$44 \$41 \$40 GND GND nfet_03v3 L=0.28U W=0.84U AS=0.2184P AD=0.5124P PS=1.36U
+ PD=2.9U
M$45 GND \$55 \$44 GND nfet_03v3 L=0.28U W=0.84U AS=0.5124P AD=0.2184P PS=2.9U
+ PD=1.36U
M$46 \$55 \$44 GND GND nfet_03v3 L=0.28U W=0.84U AS=0.2184P AD=0.5124P PS=1.36U
+ PD=2.9U
M$47 GND \$48 \$47 GND nfet_03v3 L=0.28U W=0.84U AS=0.5124P AD=0.2184P PS=2.9U
+ PD=1.36U
M$48 \$48 \$47 GND GND nfet_03v3 L=0.28U W=0.84U AS=0.2184P AD=0.5124P PS=1.36U
+ PD=2.9U
.ENDS SRAM8bit
