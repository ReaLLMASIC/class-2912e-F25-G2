* Extracted by KLayout with GF180MCU LVS runset on : 23/11/2025 19:04

.SUBCKT FF VDD Q RST GND CLK D
M$1 \$3 \$7 VDD VDD pfet_03v3 L=0.28U W=0.84U AS=0.546P AD=0.2184P PS=2.98U
+ PD=1.36U
M$2 VDD \$6 \$3 VDD pfet_03v3 L=0.28U W=0.84U AS=0.2184P AD=0.546P PS=1.36U
+ PD=2.98U
M$3 Q RST VDD VDD pfet_03v3 L=0.28U W=0.84U AS=0.546P AD=0.2184P PS=2.98U
+ PD=1.36U
M$4 VDD \$3 Q VDD pfet_03v3 L=0.28U W=0.84U AS=0.2184P AD=0.546P PS=1.36U
+ PD=2.98U
M$5 \$6 \$5 VDD VDD pfet_03v3 L=0.28U W=0.84U AS=0.546P AD=0.546P PS=2.98U
+ PD=2.98U
M$6 \$7 CLK VDD VDD pfet_03v3 L=0.28U W=0.84U AS=0.546P AD=0.546P PS=2.98U
+ PD=2.98U
M$7 \$16 \$5 VDD VDD pfet_03v3 L=0.28U W=0.84U AS=0.546P AD=0.2184P PS=2.98U
+ PD=1.36U
M$8 VDD \$7 \$16 VDD pfet_03v3 L=0.28U W=0.84U AS=0.2184P AD=0.546P PS=1.36U
+ PD=2.98U
M$9 RST \$16 VDD VDD pfet_03v3 L=0.28U W=0.84U AS=0.546P AD=0.2184P PS=2.98U
+ PD=1.36U
M$10 VDD Q RST VDD pfet_03v3 L=0.28U W=0.84U AS=0.2184P AD=0.546P PS=1.36U
+ PD=2.98U
M$11 \$30 D VDD VDD pfet_03v3 L=0.28U W=0.84U AS=0.546P AD=0.2184P PS=2.98U
+ PD=1.36U
M$12 VDD CLK \$30 VDD pfet_03v3 L=0.28U W=0.84U AS=0.2184P AD=0.546P PS=1.36U
+ PD=2.98U
M$13 \$26 \$30 VDD VDD pfet_03v3 L=0.28U W=0.84U AS=0.546P AD=0.2184P PS=2.98U
+ PD=1.36U
M$14 VDD \$34 \$26 VDD pfet_03v3 L=0.28U W=0.84U AS=0.2184P AD=0.546P PS=1.36U
+ PD=2.98U
M$15 \$37 D VDD VDD pfet_03v3 L=0.28U W=0.84U AS=0.546P AD=0.546P PS=2.98U
+ PD=2.98U
M$16 \$39 CLK VDD VDD pfet_03v3 L=0.28U W=0.84U AS=0.546P AD=0.2184P PS=2.98U
+ PD=1.36U
M$17 VDD \$37 \$39 VDD pfet_03v3 L=0.28U W=0.84U AS=0.2184P AD=0.546P PS=1.36U
+ PD=2.98U
M$18 \$34 \$26 VDD VDD pfet_03v3 L=0.28U W=0.84U AS=0.546P AD=0.2184P PS=2.98U
+ PD=1.36U
M$19 VDD \$39 \$34 VDD pfet_03v3 L=0.28U W=0.84U AS=0.2184P AD=0.546P PS=1.36U
+ PD=2.98U
M$20 \$13 \$7 GND GND nfet_03v3 L=0.28U W=0.42U AS=0.26685P AD=0.1092P PS=2.11U
+ PD=0.94U
M$21 \$13 \$6 \$3 GND nfet_03v3 L=0.28U W=0.42U AS=0.2646P AD=0.1092P PS=2.1U
+ PD=0.94U
M$22 \$14 RST GND GND nfet_03v3 L=0.28U W=0.42U AS=0.26685P AD=0.1092P PS=2.11U
+ PD=0.94U
M$23 \$14 \$3 Q GND nfet_03v3 L=0.28U W=0.42U AS=0.2646P AD=0.1092P PS=2.1U
+ PD=0.94U
M$24 \$6 \$5 GND GND nfet_03v3 L=0.28U W=0.42U AS=0.2646P AD=0.2646P PS=2.1U
+ PD=2.1U
M$25 \$15 \$5 GND GND nfet_03v3 L=0.28U W=0.42U AS=0.26685P AD=0.1092P PS=2.11U
+ PD=0.94U
M$26 \$15 \$7 \$16 GND nfet_03v3 L=0.28U W=0.42U AS=0.2646P AD=0.1092P PS=2.1U
+ PD=0.94U
M$27 \$17 \$16 GND GND nfet_03v3 L=0.28U W=0.42U AS=0.26685P AD=0.1092P
+ PS=2.11U PD=0.94U
M$28 \$17 Q RST GND nfet_03v3 L=0.28U W=0.42U AS=0.2646P AD=0.1092P PS=2.1U
+ PD=0.94U
M$29 \$7 CLK GND GND nfet_03v3 L=0.28U W=0.42U AS=0.2646P AD=0.2646P PS=2.1U
+ PD=2.1U
M$30 \$35 D GND GND nfet_03v3 L=0.28U W=0.42U AS=0.26685P AD=0.1092P PS=2.11U
+ PD=0.94U
M$31 \$35 CLK \$30 GND nfet_03v3 L=0.28U W=0.42U AS=0.2646P AD=0.1092P PS=2.1U
+ PD=0.94U
M$32 \$36 \$30 GND GND nfet_03v3 L=0.28U W=0.42U AS=0.26685P AD=0.1092P
+ PS=2.11U PD=0.94U
M$33 \$36 \$34 \$26 GND nfet_03v3 L=0.28U W=0.42U AS=0.2646P AD=0.1092P PS=2.1U
+ PD=0.94U
M$34 \$37 D GND GND nfet_03v3 L=0.28U W=0.42U AS=0.2646P AD=0.2646P PS=2.1U
+ PD=2.1U
M$35 \$38 CLK GND GND nfet_03v3 L=0.28U W=0.42U AS=0.26685P AD=0.1092P PS=2.11U
+ PD=0.94U
M$36 \$38 \$37 \$39 GND nfet_03v3 L=0.28U W=0.42U AS=0.2646P AD=0.1092P PS=2.1U
+ PD=0.94U
M$37 \$40 \$26 GND GND nfet_03v3 L=0.28U W=0.42U AS=0.26685P AD=0.1092P
+ PS=2.11U PD=0.94U
M$38 \$40 \$39 \$34 GND nfet_03v3 L=0.28U W=0.42U AS=0.2646P AD=0.1092P PS=2.1U
+ PD=0.94U
.ENDS FF
