* Extracted by KLayout with GF180MCU LVS runset on : 15/11/2025 23:34

.SUBCKT OTA GND VDD IREF VOUT VINN VINP
M$1 VDD \$8 \$8 VDD pfet_03v3 L=1U W=1U AS=0.65P AD=0.26P PS=3.3U PD=1.52U
M$2 VOUT \$8 VDD VDD pfet_03v3 L=1U W=1U AS=0.26P AD=0.65P PS=1.52U PD=3.3U
M$3 IREF IREF GND GND nfet_03v3 L=4U W=1U AS=0.61P AD=0.61P PS=3.22U PD=3.22U
M$4 \$4 IREF GND GND nfet_03v3 L=4U W=1U AS=0.61P AD=0.61P PS=3.22U PD=3.22U
M$5 \$4 VINN \$8 GND nfet_03v3 L=1U W=0.9U AS=0.549P AD=0.234P PS=3.02U PD=1.42U
M$6 VOUT VINP \$4 GND nfet_03v3 L=1U W=0.9U AS=0.234P AD=0.549P PS=1.42U
+ PD=3.02U
.ENDS OTA
